;; a_res.il: lane A (gaps round 2) live check, results of the analyses without a SPICE
;; form (inventory rows 20, 21). In chkLib (sfyprobe_a): rc (V0 vsin -> IPRB0 iprobe -> R0
;; -> out, C0 to ground, R1 out to ground) and rp (two ports around R0). One maestro view on
;; rc: test TR (dc with saveOppoint, noise with output nodes, stb, pss + pac) on rc and TP
;; (sp) on rp; one single run; then, per point directory, every OCEAN result with its
;; outputs and what v()/i() and getData answer for each (a waveform, a number, nothing), and
;; SfyAdeResults of the history into out/a_res (what the waves files hold and skip).

chkW = getShellEnvVar("SFYCHECK_WORK")
chkOut = strcat(chkW "/out/a_res")
chkSim = strcat(chkW "/sim_ares")
system(sprintf(nil "rm -rf '%s' '%s'; mkdir -p '%s'" chkOut chkSim chkOut))
envSetVal("asimenv.startup" "projectDir" 'string chkSim)

procedure(chkSet(inst name value)
  let((c)
    c = cdfFindParamByName(cdfGetInstCDF(inst) name)
    if(c then c~>value = value t else chkLine(sprintf(nil "no CDF param %s on %s" name inst~>name) nil))))

procedure(chkStub(cv inst nets)
  let((bb c p2 w ib dx)
    ib = inst~>bBox
    foreach(term inst~>master~>terminals
      when(assoc(term~>name nets)
        bb = dbTransformBBox(car(term~>pins)~>fig~>bBox inst~>transform)
        c = list((xCoord(car(bb)) + xCoord(cadr(bb))) / 2.0 (yCoord(car(bb)) + yCoord(cadr(bb))) / 2.0)
        dx = if(xCoord(c) < (xCoord(car(ib)) + xCoord(cadr(ib))) / 2.0 - 0.01 then -0.25 else 0.25)
        p2 = list(xCoord(c) + dx yCoord(c))
        w = schCreateWire(cv "draw" "full" list(c p2) 0.0625 0.0625 0.0)
        schCreateWireLabel(cv car(w) p2 cadr(assoc(term~>name nets)) "lowerLeft" "R0" "stick" 0.0625 nil)))))

let((cv v i r c r1 p1 p2)
  cv = dbOpenCellViewByType(chkLib "rc" "schematic" "schematic" "w")
  v = schCreateInst(cv dbOpenCellViewByType("analogLib" "vsin" "symbol") "V0" 0:0 "R0")
  i = schCreateInst(cv dbOpenCellViewByType("analogLib" "iprobe" "symbol") "IPRB0" 3:0 "R0")
  r = schCreateInst(cv dbOpenCellViewByType("analogLib" "res" "symbol") "R0" 6:0 "R0")
  c = schCreateInst(cv dbOpenCellViewByType("analogLib" "cap" "symbol") "C0" 9:0 "R0")
  r1 = schCreateInst(cv dbOpenCellViewByType("analogLib" "res" "symbol") "R1" 12:0 "R0")
  foreach(kv '(("vdc" "1") ("va" "0.1") ("freq" "1M") ("acm" "1") ("pacm" "1")) chkSet(v car(kv) cadr(kv)))
  chkSet(r "r" "1k") chkSet(r1 "r" "1k") chkSet(c "c" "1n")
  chkStub(cv v '(("PLUS" "in") ("MINUS" "gnd!")))
  chkStub(cv i '(("PLUS" "in") ("MINUS" "in2")))
  chkStub(cv r '(("PLUS" "in2") ("MINUS" "out")))
  chkStub(cv c '(("PLUS" "out") ("MINUS" "gnd!")))
  chkStub(cv r1 '(("PLUS" "out") ("MINUS" "gnd!")))
  chkE("rc check" lambda(() schCheck(cv)))
  dbSave(cv) dbClose(cv)
  cv = dbOpenCellViewByType(chkLib "rp" "schematic" "schematic" "w")
  p1 = schCreateInst(cv dbOpenCellViewByType("analogLib" "port" "symbol") "PORT1" 0:0 "R0")
  r = schCreateInst(cv dbOpenCellViewByType("analogLib" "res" "symbol") "R0" 3:0 "R0")
  p2 = schCreateInst(cv dbOpenCellViewByType("analogLib" "port" "symbol") "PORT2" 6:0 "R0")
  chkSet(p1 "num" "1") chkSet(p2 "num" "2") chkSet(r "r" "50")
  chkStub(cv p1 '(("PLUS" "a") ("MINUS" "gnd!")))
  chkStub(cv r '(("PLUS" "a") ("MINUS" "b")))
  chkStub(cv p2 '(("PLUS" "b") ("MINUS" "gnd!")))
  chkE("rp check" lambda(() schCheck(cv)))
  dbSave(cv) dbClose(cv))

chkFreq = '(("start" "1k") ("stop" "100k") ("incrType" "Logarithmic") ("stepTypeLog" "Points Per Decade") ("dec" "2"))
chkS = chkE("open maestro" list('maeOpenSetup chkLib "rc" "maestro" ?mode "a"))
chkHist = nil
when(chkS
  chkE("TR" lambda(() maeCreateTest("TR" ?lib chkLib ?cell "rc" ?view "schematic" ?simulator "spectre" ?session chkS)))
  errset(maeSetAnalysis("TR" "tran" ?enable nil ?session chkS))
  chkE("TR dc" lambda(() maeSetAnalysis("TR" "dc" ?enable t ?options '(("saveOppoint" t)) ?session chkS)))
  chkE("TR noise" lambda(() maeSetAnalysis("TR" "noise" ?enable t ?options append(chkFreq '(("outType" "voltage") ("p" "/out") ("n" "/gnd!") ("iprobe" "/V0"))) ?session chkS)))
  chkE("TR stb" lambda(() maeSetAnalysis("TR" "stb" ?enable t ?options append(chkFreq '(("probe" "/IPRB0"))) ?session chkS)))
  chkE("TR pss" lambda(() maeSetAnalysis("TR" "pss" ?enable t ?options '(("fund" "1M") ("harms" "3")) ?session chkS)))
  chkE("TR pac" lambda(() maeSetAnalysis("TR" "pac" ?enable t ?options chkFreq ?session chkS)))
  chkE("ZP" lambda(() maeCreateTest("ZP" ?lib chkLib ?cell "rp" ?view "schematic" ?simulator "spectre" ?session chkS)))
  errset(maeSetAnalysis("ZP" "tran" ?enable nil ?session chkS))
  chkE("TP sp" lambda(() maeSetAnalysis("ZP" "sp" ?enable t ?options append(chkFreq '(("ports" "/PORT1 /PORT2"))) ?session chkS)))
  chkE("TR out" lambda(() maeAddOutput("vo" "TR" ?outputType "point" ?expr "VDC(\"/out\")" ?session chkS)))
  chkE("save" lambda(() maeSaveSetup(?lib chkLib ?cell "rc" ?view "maestro" ?session chkS)))
  chkHist = chkE("run" lambda(() maeRunSimulation(?session chkS)))
  chkE("wait" lambda(() maeWaitUntilDone('All)))
  ;; Per point: each result, its outputs, and what the readers answer.
  let((sdb h psf)
    sdb = axlGetMainSetupDB(chkS)
    h = car(errset(axlGetHistoryEntry(sdb chkHist)))
    foreach(test '("TR" "ZP")
      psf = car(errset(axlGetPointPsfDir(h test ?cornerName "" ?designPointId 1)))
      chkLine(sprintf(nil "%s psf" test) psf)
      when(stringp(psf) && car(errset(openResults(psf)))
        foreach(r car(errset(results()))
          when(car(errset(selectResult(r)))
            let((outs)
              outs = car(errset(outputs()))
              chkLine(sprintf(nil "%s result %L outputs" test r) outs)
              foreach(o if(length(outs) > 6 then nil else outs)
                chkLine(sprintf(nil "%s %L %L v" test r o)
                  let((w) w = car(errset(v(o)))
                    list(type(w) if(drIsWaveform(w) drVectorLength(drGetWaveformXVec(w)) w))))
                chkLine(sprintf(nil "%s %L %L getData" test r o)
                  let((w) w = car(errset(getData(o)))
                    list(type(w) if(drIsWaveform(w) list(drVectorLength(drGetWaveformXVec(w)) drGetElem(drGetWaveformXVec(w) 0) drGetElem(drGetWaveformYVec(w) 0)) w)))))))))))
  chkE("close" lambda(() maeCloseSession(?session chkS ?forceClose t))))
chkThat("a history ran" stringp(chkHist))
when(stringp(chkHist)
  chkLine("history" chkHist)
  chkThat("SfyAdeResults PASS" SfyAdeResults(chkOut chkLib "rc" chkHist))
  foreach(f sort(getDirFiles(chkOut) nil)
    when(rexMatchp("\\.txt$" f)
      let((port l heads)
        port = infile(strcat(chkOut "/" f))
        while(gets(l port) when(rexMatchp("^#" l) heads = cons(l heads)))
        close(port)
        chkLine(sprintf(nil "waves %s" f) reverse(heads))))))
chkThat("SfyExport rc rp" SfyExport(strcat(chkOut "/cells.sfyx") chkLib '("rc" "rp")))
system(sprintf(nil "rm -rf '%s'" chkSim))
